** sch_path: /home/barnik-chakraborty/college_labs/nmos_diode.sch
**.subckt nmos_diode
XM1 net1 net1 0 0 sky130_fd_pr__nfet_01v8 L=0.15 W=1 nf=1 ad=0.29 as=0.29 pd=2.58 ps=2.58 nrd=0.29 nrs=0.29 sa=0 sb=0 sd=0 mult=1
V1 net1 0 0
**** begin user architecture code

.lib /usr/local/share/pdk/sky130A/libs.tech/ngspice/sky130.lib.spice tt
.dc V1 0 1.8 0.01
.save all

**** end user architecture code
**.ends
.end
