** sch_path: /home/barnik-chakraborty/episode_2/inv_test.sch
**.subckt inv_test
x1 vin Vdd 0 vout inv_vtc
vin vin 0 PULSE(0 1.8 0 .1n .1n 10n 20n 10)
Vdd Vdd 0 1.8
C1 vout 0 .1p
**** begin user architecture code

.lib /usr/local/share/pdk/sky130A/libs.tech/ngspice/sky130.lib.spice tt
.dc Vin 0 1.8 1m
.tran .02n 40n
.save all
.end

**** end user architecture code
**.ends

* expanding   symbol:  inv_vtc.sym # of pins=4
** sym_path: /home/barnik-chakraborty/episode_2/inv_vtc.sym
** sch_path: /home/barnik-chakraborty/episode_2/inv_vtc.sch
.subckt inv_vtc vin vdd gnd vout
*.ipin vin
*.ipin vdd
*.ipin gnd
*.opin vout
XM1 vout vin gnd gnd sky130_fd_pr__nfet_01v8 L=0.15 W=1 nf=1 ad=0.29 as=0.29 pd=2.58 ps=2.58 nrd=0.29 nrs=0.29 sa=0 sb=0 sd=0
+ mult=1
XM2 vout vin vdd vdd sky130_fd_pr__pfet_01v8 L=0.15 W=2 nf=1 ad=0.58 as=0.58 pd=4.58 ps=4.58 nrd=0.145 nrs=0.145 sa=0 sb=0 sd=0
+ mult=1
.ends

.end
